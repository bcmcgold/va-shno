// code adapted from https://ieeexplore.ieee.org/stamp/stamp.jsp?arnumber=1518185&casa_token=Z1p-52ykemYAAAAA:Dft-5QeNP1V7bMusI9AVwok1xkGey0boWdx8x8tAd-3CRqZFH-gsgkWjHY3iTU1lhAEXDTelvw
// Updated version of sho_phys_Tnoise.va with making ISF analytical and able to model DC nonlinearity based on user input
// this device is based on clamshell orbit (other orbital trajectories will have different analytical equations for ISF)
`include "disciplines.vams"
`include "constants.vams"

module sho(sh_dc, sh_rf, mtj);

// define electrical nodes
input sh_dc, sh_rf;
inout mtj;
electrical sh_dc, sh_rf, mtj, alpha; // introduce internal node alpha
// define branches from internal node alpha
branch (alpha) alpha1;
branch (alpha) alpha2;

// define circuit-level variables
real Rp = 1200; // parallel MTJ resistance (nanopillar only), Ohms
real Rap = 2400; // anti-parallel MTJ resistance (nanopillar only), Ohms
real Rhm = 200; // heavy metal resistance
real whm = 200e-9; // width of heavy metal (where current applied), m
real thm = 5e-9; // heavy metal thickness, m
real Ash = whm*thm; // cross-sectional area of SH strip where current flows in, m2
real gammap = 30*`M_PI/180; // spin polarization angle from x-axis, radians
real thetaSH = 0.07; // spin Hall angle

// define oscillator-level variables for phase model
real period, phase, omega, psi;
parameter real init_phase=0.0 from[-180:180]; // degrees, can be set from hspice netlist

// construct Fourier representation of ISF
real isf_odd, isf_even, isf_bx, isf_by, isf_bz, mx, my, my0, mz, dmeq, fdmeq[1:3], fs[1:5], fb[1:4];

// material parameters (relevant for thermal field)
real damping = 0.02; // dimensionless gilbert damping
real Ms = 800e3; // saturation magnetization, A/m
real wmtj = 120e-9; // MTJ width, m
real lmtj = 200e-9; // MTJ length, m
real tfl = 1.5e-9; // free layer thickness, m
real Vfl = `M_PI/4*wmtj*lmtj*tfl; // magnetic free layer volume

// physics constants
real kB = 1.38e-23; // Boltzmann constant J/K
real g = 2; // g-factor
real muB = 9.27401008e-24; // Bohr magneton, A m2
real hbar = 1.055e-34; // reduced Planck constant, J s
real ec = 1.602e-19; // elementary charge, C
real gammae = g*muB/hbar; // free electron gyromagnetic ratio, rad/(s T)
real sigma = hbar*thetaSH/(2*ec*Ms*Ash*tfl);

// user variables for random thermal field generation (may change)
real T = 300; // K
real dt_step = 15e-12; // timestep for computing thermal field
parameter seed = 12345; // can be set from hspice netlist
// constants/variables for thermal field (don't change)
real dt_sim = 0; // for keeping track of when thermal field should be changed
real Tx, Ty, Tz; // thermal field components (chosen from normal dist)
real Btherm = sqrt(2*damping*kB*T/(Ms*gammae/(2*`M_PI)*Vfl*dt_step));

analog begin
  @(initial_step) begin
    // initialize thermal field components
  	Tx = $rdist_normal(seed,0.0,1.0);
  	Ty = $rdist_normal(seed,0.0,1.0);
  	Tz = $rdist_normal(seed,0.0,1.0);

    //omega = 2.0*`M_PI*$table_model(V(sh_dc), "fg_vs_vdc.tbl", "L"); // free-running angular frequency
    omega = 2.0*`M_PI*2.26e9;
    period = 2.0*`M_PI/omega; // s

    // Get equilibrium orbit Fourier components based on Vdc
    //mx = $table_model(V(sh_dc), "mx_ft_vs_vdc.tbl", "L");
    //my = $table_model(V(sh_dc), "my_ft_vs_vdc.tbl", "L");
    //my0 = $table_model(V(sh_dc), "my0_ft_vs_vdc.tbl", "L");
    //mz = $table_model(V(sh_dc), "mz_ft_vs_vdc.tbl", "L");
    mx = 0.99;
    my = 0.34;
    my0 = 0.60;
    mz = 0.21;

    // equilibrium magnetization Fourier components
    fdmeq[1] = mx*mx+4*my*my+mz*mz;
    fdmeq[2] = (mx-mz)*(mx+mz);
    fdmeq[3] = -4*my*my;

    // spin toruqe ISF even and odd Fourier components
    fs[1] = 2*mx*(my*my+4*my*my0+2*(my0*my0+mz*mz));
    fs[2] = -2*(mx*mx*(2*my+my0)+mz*mz*(2*my-my0))/4;
    fs[3] = 3*mx*my*my/9;
    fs[4] = my*(mx*mx-mz*mz)/16;
    fs[5] = -mx*my*my/25;

    // field ISF sin (1,2) and cos (3,4) Fourier coefficients
    fb[1] = (3*my-2*my0)*mz;
    fb[2] = my*mz/9;
    fb[3] = -(3*my+2*my0)*mx;
    fb[4] = mx*my/9;
  end

	// Sets input impedance of spin Hall RF and DC ports
	I(sh_rf) <+ V(sh_rf)/Rhm;
	I(sh_dc) <+ V(sh_dc)/Rhm;

  // real perturbed time is given by
  // $abstime + V(alpha)
  // but our isf table has only one period
  // so take the modulus of period
  psi = omega*($abstime+V(alpha))+`M_PI/180*init_phase;

  // calculate ISF based on analytical expression
  dmeq = omega*omega/2*(fdmeq[1]+fdmeq[2]*cos(2*psi)+fdmeq[3]*cos(4*psi));
  isf_odd = omega*gammae*sigma*sin(gammap)/(4*Rhm*dmeq)*(fs[1]*cos(psi)+fs[3]*cos(3*psi)+fs[5]*cos(5*psi));
  isf_even = omega*gammae*sigma*-cos(gammap)/(4*Rhm*dmeq)*(fs[2]*sin(2*psi)+fs[4]*sin(4*psi));
  isf_bx = omega*gammae/(2*dmeq)*(fb[1]*sin(psi)+fb[2]*sin(3*psi));
  isf_by = omega*gammae/dmeq*mx*mz;
  isf_bz = omega*gammae/(2*dmeq)*(fb[3]*cos(psi)+fb[4]*cos(3*psi));

    // SHIL amplitude, V
    //V2f = 2.5e11*Ash*Rhm*$table_model($abstime,"shil_square.tbl", "L");
    V2f = 1.5e11*Ash*Rhm;

    // SHIL signal
	Vshil = -V2f*cos(2*omega*$abstime);

  // effective thermal field
	if ($abstime-dt_sim >= dt_step) begin
		dt_sim = $abstime;
		Tx = $rdist_normal(seed,0.0,1.0);
		Ty = $rdist_normal(seed,0.0,1.0);
		Tz = $rdist_normal(seed,0.0,1.0);
	end
	Tfield = Btherm*(Tx*isf_bx+Ty*isf_by+Tz*isf_bz);

  // RHS of phase differential equation
  // linramp goes from 0 to 1 in first ns to set initial condition alpha(t=0) = 0
  //I(alpha1) <+ -$table_model($abstime,"linramp.tbl", "L")*(isf_odd*V(sh_rf)+isf_even*Vshil+Tfield);
  I(alpha1) <+ -$table_model($abstime,"linramp.tbl", "L")*((isf_odd+isf_even)*(V(sh_rf)+Vshil)+Tfield);
  // LHS of phase differential equation
  I(alpha2) <+ ddt(V(alpha));

  // output variables for data collection, debugging, etc.
	phase = V(alpha)*omega/`M_PI + init_phase/180; // output only, units of pi rad
	vproberf = V(sh_rf);
	vprobemtj = V(mtj);
	K1f = isf_odd*V(sh_rf);
	K2f = isf_even*Vshil;

  // look up table to generate output
  V(mtj) <+ I(mtj)*((Rp+Rap+Rhm)/2+(Rap-Rp)/2*mx*sin(psi)); // mxoutput is -sin
end
endmodule
